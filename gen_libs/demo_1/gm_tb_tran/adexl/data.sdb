ADE simulation setup
Run mode: Single Run, Sweeps and Corners
Tests:
  tb_tran: demo_1/gm_tb_tran/config, simulator spectre
Global variables:
  tsim = 3.000000e-09
  cload = 5.000000e-15 2.000000e-14 1.000000e-13
  rload = 1.000000e+03
  tper = 2.500000e-10
  tr = 1.500000e-11
  vamp = 1.200000e-01
  vbias = 4.500000e-01
  vcm = 7.000000e-01
  vdd = 1.000000e+00
  tstep = 1.000000e-12
Corners (nominal off):
  model folders: /tools/cadence/GPDK/cds_ff_mpt_v_0.3/models/spectre
  tt: temperature=25; cds_ff_mpt.scs[tt]
  ff: temperature=25; cds_ff_mpt.scs[ff]
  ss (off): temperature=25; cds_ff_mpt.scs[ss]
  sf (off): temperature=25; cds_ff_mpt.scs[sf]
  fs (off): temperature=25; cds_ff_mpt.scs[fs]
  ff_hot (off): temperature=65; cds_ff_mpt.scs[ff]
  ss_hot (off): temperature=65; cds_ff_mpt.scs[ss]
  ss_cold (off): temperature=0; cds_ff_mpt.scs[ss]
