ADE simulation setup
Run mode: Single Run, Sweeps and Corners
Tests:
  adc_sar_templates:capdac_tb_noise:1: adc_sar_templates/capdac_tb_noise/schematic, simulator spectre
Global variables:
  prs = 1000
  fsamp = 10e9
