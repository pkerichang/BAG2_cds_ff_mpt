ADE simulation setup
Run mode: Single Run, Sweeps and Corners
Tests:
  adc_sar_testbenches:tisaradc_top_tb_libgen:1: adc_sar_testbenches/tisaradc_top_tb_libgen/schematic, simulator spectre
    Outputs: tpf_adcout0_0; tpr_adcout0_0; tf_adcout0_0; tpr_clk; tpf_clk; tf_clk
Global variables:
  cl = 1.7f, 3.2f, 6.3f, 12.5f, 24.9f, 49.6f, 99.1f
  vretin = 0
  pvckcm = 0.4
  vdd = 0.8
Corners (nominal off):
  model folders: /tools/tstech16/CLN16FFC/PDK/models
  tt (off): temperature=25; vdd=0.8; toplevel.scs[top_tt], cln16ffcll_1d8_sp_v0d9_2p2_usage.scs[pre_simu]
  ff (off): temperature=0; vdd=0.88
  ss (off): temperature=125; vdd=0.72
  sf (off): temperature=25
  fs (off): temperature=25
  ff_hot (off): temperature=65
  ss_hot (off): temperature=65
  ssgnp072v125c (off): temperature=125; vdd=0.72; toplevel.scs[top_ss_gnp], cln16ffcll_1d8_sp_v0d9_2p2_usage.scs[pre_simu]
  ssgnp072v0c (off): temperature=0; vdd=0.72; toplevel.scs[top_ss_gnp], cln16ffcll_1d8_sp_v0d9_2p2_usage.scs[pre_simu]
  ffgnp0p88v125c (off): temperature=125; vdd=0.88; toplevel.scs[top_ff_gnp], cln16ffcll_1d8_sp_v0d9_2p2_usage.scs[pre_simu]
  ffgnp88v0c: temperature=0; vdd=0.88; toplevel.scs[top_ff_gnp], cln16ffcll_1d8_sp_v0d9_2p2_usage.scs[pre_simu]
