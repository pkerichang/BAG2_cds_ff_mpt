ADE simulation setup
Run mode: Single Run, Sweeps and Corners
Tests:
  adc_sar_testbenches:tisaradc_body_9b_array_8slice_core_tb_tran_rcx:1: adc_sar_testbenches/tisaradc_body_9b_array_8slice_core_tb_tran_rcx/config, simulator spectre
Global variables:
  pper = 200p
  pskew_rst = 0
  vdd = 0.9
  pvicm = 0.15
Corners (nominal off):
  model folders: /tools/tstech16/CLN16FFC/PDK/models
  tt: temperature=25; vdd=0.9; toplevel.scs[top_tt]
  ssgnp072v125c: temperature=125; vdd=0.9; toplevel.scs[top_ss]
  ssgnp072v0c: temperature=0; vdd=0.9; toplevel.scs[top_ss]
  ffgnp0p88v125c: temperature=125; vdd=0.9; toplevel.scs[top_ff]
  ffgnp88v0c: temperature=0; vdd=0.9; toplevel.scs[top_ff]
